# Ansys Electronics Desktop project, version 2023.2
materials:
  vacuum: permittivity=1
  polyimide(JLC): permittivity=3.3 dielectric_loss_tangent=0.008
  air: permittivity=1.0006 permeability=1.0000004
  copper: permeability=0.999991 conductivity=58000000

design HFSSDesign1 (HFSS, HFSS Modal Network, model units mm)
options: Calculate_Lossy_Dielectrics
geometry:
  GND [copper] = box(corner=(-380mm, -30mm, 0mm), size=(760mm, 80mm, 0.018mm))
  Substrate [polyimide(JLC)] = box(corner=(-380mm, -30mm, 0.018mm), size=(760mm, 80mm, 25um))
  port = rectangle(corner=(0.5mm, 50mm, 0.055mm), z_size=-0.037mm, x_size=-1mm)
  Radiation [air] = box(corner=(-400mm, -95mm, -30mm), size=(800mm, 230mm, 60mm))
  Array [copper] = imported_body()
  Box1 = box(corner=(32mm, 40.25mm, 0.043mm), size=(-4mm, 1.5mm, 0.012mm))
  Array.unite(Box1)
  group feed_Group = Array
boundaries and excitations:
  PerfE2: Perfect E Objects=GND
  Rad1: Radiation Objects=Radiation
  PerfE4: Perfect E Objects=Array
  1: Lumped Port Objects=port LumpedPortType=Modal Modes{Mode1{IntLine{(0mm, 50000mm, 20mm) -> (0, 50, 0.055)} CharImp=Zpi}} Impedance=50ohm
  reference conductors: GND
setups:
  Setup1: HfssDriven Frequency=2.4GHz MaxDeltaS=0.02 MaximumPasses=12 MinimumPasses=1 MinimumConvergedPasses=1 PercentRefinement=30 BasisOrder=1 PortAccuracy=2 DrivenSolverType="Direct Solver"
    sweep Sweep: 1.2GHz to 3.6GHz, 401 points; Type=Fast SaveFields
source amplitudes:
  1:1: 1V 0deg
radiation setups:
  Infinite Sphere1: Infinite Sphere Theta=-180deg..180deg step 2deg Phi=0deg..90deg step 90deg
